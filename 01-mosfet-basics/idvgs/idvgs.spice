* NMOS Id-Vgs family, SKY130 tt corner
.lib /foss/pdks/sky130A/libs.tech/ngspice/sky130.lib.spice tt

XM1 d g 0 0 sky130_fd_pr__nfet_01v8 W=10 L=1
Vds d 0 1.8
Vgs g 0 0

.dc Vgs 0 1.8 0.01

.control
run
let id = -i(Vds)
wrdata idvgs.csv id
.endc
.end
